* Auto-generated testbench for protection device: bD1 (SMBJ18A)
* Type: diode, protecting VIN_POWER
* Model: generic Zener diode — real TVS clamping may differ

* Generic semiconductor models for Phase 1 simulation
.model D_GENERIC D(IS=1e-14 N=1.05 BV=100 IBV=1e-10)
.model D_SCHOTTKY D(IS=1e-6 N=1.05 BV=40 IBV=1e-8 RS=0.5)
.model D_ZENER3V3 D(IS=1e-14 N=1.05 BV=3.3 IBV=5e-3)
.model D_ZENER5V1 D(IS=1e-14 N=1.05 BV=5.1 IBV=5e-3)
.model NPN_GENERIC NPN(IS=1e-14 BF=200 VAF=100 CJC=5p CJE=10p TF=0.3n)
.model PNP_GENERIC PNP(IS=1e-14 BF=200 VAF=100 CJC=5p CJE=10p TF=0.6n)
.model NMOS_GENERIC NMOS(VTO=1.5 KP=1e-2 LAMBDA=0.01)
.model PMOS_GENERIC PMOS(VTO=-1.5 KP=5e-3 LAMBDA=0.01)

* TVS/ESD diode: cathode to protected net, anode to clamp (GND)
DbD1 GND_POWER VIN_POWER D_GENERIC

* Voltage ramp on protected net to find clamping voltage
Vramp VIN_POWER 0 DC 0

.control
dc Vramp 0 9.9 49.5m
let idiode = abs(i(Vramp))
meas dc v_clamp_1mA when idiode=1m
meas dc v_clamp_10mA when idiode=10m
echo "v_clamp_1mA=$&v_clamp_1mA v_clamp_10mA=$&v_clamp_10mA rail_v=3.3" > C:/Users/samch/Documents/GitHub/SWARM_COMMs/SWARM_PCB_Rev_2/spice_runs/protection-device_idx0.out
quit
.endc

.end
