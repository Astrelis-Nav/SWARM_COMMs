* Testbench for bridge circuit: h_bridge
* Tests low-side switch (dQ4) characteristic with pull-up load
* Device: IPD50N10S3L-16 (Vth typ 2V, Rds(on) 16mΩ at Vgs=10V, Id=50A, Vds=100V)

* IPD50N10S3L-16 approximation
* KP tuned: Rds(on) ≈ 1/(2*KP*(Vgs-Vth)) = 16mΩ at Vgs=10V, Vth=2V → KP=3.9 A/V²
.model IPD50N10S3L16 NMOS(VTO=2.0 KP=3.9 LAMBDA=0.02 RD=0.008 RS=0.008)

* Supply at actual operating voltage (12V_TXRX rail)
VDD vdd 0 DC 12

* Pull-up load: simulates inductive/resistive load driven from VDD
* Current path: VDD -> Rpull -> mid -> dQ4 -> GND
Rpull vdd mid 100

* Low-side FET: drain at midpoint, source/body at GND, gate swept
MdQ4 mid lo_gate 0 0 IPD50N10S3L16 L=1u W=1u

* Gate sweep source (UCC27211D drives to VDD = 12V)
Vgate lo_gate 0 DC 0

.control
dc Vgate 0 12 0.05
let id_lo = abs(i(VDD))
meas dc vth_lo when id_lo=100u
meas dc id_on find id_lo at=10
echo "vth_lo=$&vth_lo id_on=$&id_on v_supply=12 topology=h_bridge" > C:/Users/samch/Documents/GitHub/SWARM_COMMs/SWARM_PCB_Rev_2/spice_runs/bridge-circuit_idx0.out
quit
.endc

.end
